Full stereo WCF and three winding power supply - feasibility only
.include ../models/6h30pi_eb.lib
.options method=gear reltol=3e-5 abstol=1e-10
RSW1L SEL_L IN_L .01
RSW1R SEL_R IN_R .01
RRV1LT SEL_L WIP_L .001
RRV1LB WIP_L 0 10k
RRV1RT SEL_R WIP_R .001
RRV1RB WIP_R 0 10k
R1 IN_L ATT_L 8.2k
R2 ATT_L 0 1k
R3 HP_L 0 100k
R4 IN_R ATT_R 8.2k
R5 ATT_R 0 1k
R6 HP_R 0 100k
XV1UP L_PA L_GU L_MID H30
XV1LO L_MID L_GL L_K H30
RV1H HPLUS HMINUS 7
C1 WIP_L L_GI 4.7u
R7 BPLUS L_BIAS 100k
R8 L_BIAS 0 100k
C2 L_BIAS 0 47u
R9 L_BIAS L_GI 47k
R10 L_GI L_GU 100
R11 BPLUS L_PA 127
C3 L_PA L_GB 4.7u
R12 L_GB L_GL 100
R13 L_GB 0 100k
R14 L_K 0 68
C4 L_K 0 2200u
C5 L_MID L_OUT 1000u
R15 L_MID 0 100k
R16 L_OUT 0 10k
RK1COIL AUX12 COIL_LO 1000
SK1 L_OUT HP_L AUX12 COIL_LO CONTACT
XV2UP R_PA R_GU R_MID H30
XV2LO R_MID R_GL R_K H30
RV2H HPLUS HMINUS 7
C6 WIP_R R_GI 4.7u
R17 BPLUS R_BIAS 100k
R18 R_BIAS 0 100k
C7 R_BIAS 0 47u
R19 R_BIAS R_GI 47k
R20 R_GI R_GU 100
R21 BPLUS R_PA 127
C8 R_PA R_GB 4.7u
R22 R_GB R_GL 100
R23 R_GB 0 100k
R24 R_K 0 68
C9 R_K 0 2200u
C10 R_MID R_OUT 1000u
R25 R_MID 0 100k
R26 R_OUT 0 10k
RK2COIL AUX12 COIL_LO 1000
SK2 R_OUT HP_R AUX12 COIL_LO CONTACT
RF1LINK MAINS_L FUSED_L .05
RSW2L FUSED_L PRI_L .01
RSW2N MAINS_N PRI_N .01
RLK1LINK PE 0 .05
RF2LINK HV_A HV_AF .05
D1 HV_AF HV_RAW DREC
D2 HV_B HV_RAW DREC
D3 0 HV_AF DREC
D4 0 HV_B DREC
C11 HV_RAW 0 220u
R27 HV_RAW HV_IN 22
C12 HV_IN 0 220u
R28 HV_RAW 0 100k
R29 HV_IN 0 100k
MQ1 HV_IN HV_GATE HV_SOURCE HV_SOURCE MPASS
R30 HV_IN HV_GATE 47k
.model DZ_12 D(IS=1n RS=5 BV=12 IBV=.001)
D5 HV_SOURCE HV_GATE DZ_12
R31 HV_SOURCE BPLUS 4.7
Q2 HV_GATE HV_SOURCE BPLUS QHV
Q3 HV_GATE HV_FB HV_ZREF QHV
R32 BPLUS HV_FB 221k
R33 HV_FB 0 10k
R34 HV_IN HV_ZREF 82k
.model DZ_6_2 D(IS=1n RS=5 BV=6.2 IBV=.001)
D6 0 HV_ZREF DZ_6_2
C13 HV_ZREF 0 47u
C14 HV_GATE HV_FB 10n
C15 BPLUS 0 100u
R35 BPLUS 0 100k
RF3LINK HTR_A HTR_AF .05
D7 HTR_AF HRAW DSCH
D8 HTR_B HRAW DSCH
D9 HMINUS HTR_AF DSCH
D10 HMINUS HTR_B DSCH
C16 HRAW HMINUS 15000u
R36 HPLUS HADJ 121
R37 HADJ HMINUS 487
C17 HPLUS HMINUS 220u
C18 HADJ HMINUS 10u
D11 HPLUS HRAW DFAST
D12 HADJ HPLUS DFAST
R38 BPLUS HMINUS 150k
R39 HMINUS 0 47k
C19 HMINUS 0 47u
D13 AUX_A AUX_RAW DREC
D14 AUX_B AUX_RAW DREC
D15 0 AUX_A DREC
D16 0 AUX_B DREC
C20 AUX_RAW 0 1000u
R40 AUX_RAW AUX_Z 470
.model DZ_13 D(IS=1n RS=5 BV=13 IBV=.001)
D17 0 AUX_Z DZ_13
Q4 AUX_RAW AUX_Z AUX12 QHV
C21 AUX12 0 220u
R41 AUX12 0 4.7k
R42 AUX12 TIMER 330k
C22 TIMER 0 100u
.model DZ_5_1 D(IS=1n RS=5 BV=5.1 IBV=.001)
D18 TBASE TIMER DZ_5_1
R43 TBASE QB1 1k
Q5 COIL_LO QB1 QB2 QHV
Q6 COIL_LO QB2 0 QHV
R44 QB2 0 100k
D19 COIL_LO FLY_Z DFAST
.model DZ_24 D(IS=1n RS=5 BV=24 IBV=.001)
D20 AUX12 FLY_Z DZ_24
D21 AUX_A AC_PRESENT DFAST
C23 AC_PRESENT 0 470n
R45 AC_PRESENT 0 10k
R46 AC_PRESENT AC_B 47k
Q7 KILL_B AC_B 0 QHV
R47 AUX12 KILL_B 10k
Q8 TIMER KILL_B 0 QHV
R48 AUX12 REFHI 2.3k
R49 REFHI REFMID 100
R50 REFMID REFLO 100
R51 REFLO 0 2.3k
R52 AUX12 L_SENSE 100k
R53 L_OUT L_SENSE 100k
C24 L_SENSE REFMID 1u
D22 L_SENSE AUX12 DFAST
D23 0 L_SENSE DFAST
Q9 L_POSC L_SENSE L_TAILP QHV
Q10 AUX12 REFHI L_TAILP QHV
Q11 AUX12 L_SENSE L_TAILN QHV
Q12 L_NEGC REFLO L_TAILN QHV
R54 L_TAILP 0 4.7k
R55 L_TAILN 0 4.7k
R56 AUX12 L_POSC 10k
R57 AUX12 L_NEGC 10k
D24 TIMER L_POSC DFAST
D25 TIMER L_NEGC DFAST
D26 L_TAILP L_SENSE DFAST
D27 L_TAILP REFHI DFAST
D28 L_TAILN L_SENSE DFAST
D29 L_TAILN REFLO DFAST
R58 AUX12 R_SENSE 100k
R59 R_OUT R_SENSE 100k
C25 R_SENSE REFMID 1u
D30 R_SENSE AUX12 DFAST
D31 0 R_SENSE DFAST
Q13 R_POSC R_SENSE R_TAILP QHV
Q14 AUX12 REFHI R_TAILP QHV
Q15 AUX12 R_SENSE R_TAILN QHV
Q16 R_NEGC REFLO R_TAILN QHV
R60 R_TAILP 0 4.7k
R61 R_TAILN 0 4.7k
R62 AUX12 R_POSC 10k
R63 AUX12 R_NEGC 10k
D32 TIMER R_POSC DFAST
D33 TIMER R_NEGC DFAST
D34 R_TAILP R_SENSE DFAST
D35 R_TAILP REFHI DFAST
D36 R_TAILN R_SENSE DFAST
D37 R_TAILN REFLO DFAST
VMAINS MAINS_L MAINS_N SIN(0 311.12698 50)
RNEUTRAL MAINS_N 0 1G
RPE PE 0 .001
BHV HV_X HV_B V=0.6818181818181818*V(PRI_L,PRI_N)
RWHV HV_X HV_A 35
REFHV HV_B 0 10Meg
CREFHV HV_B 0 1n
BHTR HTR_X HTR_B V=0.04318181818181818*V(PRI_L,PRI_N)
RWHTR HTR_X HTR_A 0.18
REFHTR HTR_B 0 10Meg
CREFHTR HTR_B 0 1n
BAUX AUX_X AUX_B V=0.05454545454545454*V(PRI_L,PRI_N)
RWAUX AUX_X AUX_A 2
REFAUX AUX_B 0 10Meg
CREFAUX AUX_B 0 1n
BHEAT HIDEAL HMINUS V=max(0,min(6.3,V(HRAW,HMINUS)-1.5))
VHEAT HIDEAL HPLUS 0
BHEATIN HRAW HMINUS I=max(0,I(VHEAT))
VINL LSRC 0 0
VINR RSRC 0 0
RINL LSRC IN_L 100
RINR RSRC IN_R 100
RLOADL HP_L 0 16
RLOADR HP_R 0 18
.model DREC D(IS=10n RS=.25 N=1.5 CJO=20p TT=75n BV=1000)
.model DSCH D(IS=20u N=1.15 RS=.025 CJO=500p BV=45)
.model DFAST D(IS=2n N=1.7 RS=1 CJO=4p TT=4n)
.model QHV NPN(IS=1e-14 BF=80 VAF=80 CJE=12p CJC=5p)
.model MPASS NMOS(LEVEL=1 VTO=3.5 KP=.45 LAMBDA=.003 RD=1 RS=.2 CGSO=150p CGDO=30p)
.model CONTACT SW(RON=.15 ROFF=1e12 VT=9 VH=.1)

.control
tran 100u 10 0 100u
write stereo-generic.raw
quit
.endc
.end
